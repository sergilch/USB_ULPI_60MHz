* discrete USB HS receiver - generated by run_sims.py
.include /home/Projects/USB_60/AFE/Discrete/Receiver/sim/models/rx_models.lib
.options temp=27 tnom=27 reltol=1e-4 method=trap
VDD vdd 0 3.3
VSQ vsqs 0 1.32
RSQ vsqs vsq 1
CSQ vsq 0 100n
VDC vdcs 0 1.21
RDC vdcs vdisc 1
CDC vdisc 0 100n
RET1 vdd veth 18000
RET2 veth 0 10000
CET veth 0 100n
VSp sp 0 PWL( 0.00000e+00 3.30000 1.03333e-07 3.30000 1.03958e-07 0.00000 2.70000e-07 0.00000 2.70625e-07
+ 3.30000 3.53333e-07 3.30000 3.53958e-07 0.00000 5.20000e-07 0.00000 5.20625e-07 3.30000)
RSp sp hp 45
CHp hp 0 2p
OCAp hp 0 bp 0 lt_CAp
.model lt_CAp ltra r=0 g=0 l=1.125e-07 c=5.55556e-11 len=1
CBp bp 0 0.5p
OT1p bp 0 xp 0 lt_T1p
.model lt_T1p ltra r=0 g=0 l=2.7e-09 c=1.33333e-12 len=1
CXp xp 0 0.85p
OT2p xp 0 tp 0 lt_T2p
.model lt_T2p ltra r=0 g=0 l=1.35e-09 c=6.66667e-13 len=1
CTp tp 0 0.3p
RBSp tp bqp 22
LBp bqp bbp 0.8n
RLBp bqp bbp 100
Qp 0 bbp exp BFT92
LEp exp ep 0.8n
RLEp exp ep 100
REp vdd ep 220
CEp ep 0 0.5p
OT3p tp 0 up 0 lt_T3p
.model lt_T3p ltra r=0 g=0 l=1.35e-09 c=6.66667e-13 len=1
CUp up 0 1.9p
RONp up kp 4.5
CKp kp 0 1.8p
RTMp kp 0 40.2
OT4p up 0 ap 0 lt_T4p
.model lt_T4p ltra r=0 g=0 l=2.7e-09 c=1.33333e-12 len=1
CAp ap 0 0.5p
RFp ap fp 1
RFXp fp 0 1G
VSm sm 0 PWL( 0.00000e+00 0.00000 1.03333e-07 0.00000 1.03958e-07 3.30000 2.70000e-07 3.30000 2.70625e-07
+ 0.00000)
RSm sm hm 45
CHm hm 0 2p
OCAm hm 0 bm 0 lt_CAm
.model lt_CAm ltra r=0 g=0 l=1.125e-07 c=5.55556e-11 len=1
CBm bm 0 0.5p
OT1m bm 0 xm 0 lt_T1m
.model lt_T1m ltra r=0 g=0 l=2.7e-09 c=1.33333e-12 len=1
CXm xm 0 0.85p
OT2m xm 0 tm 0 lt_T2m
.model lt_T2m ltra r=0 g=0 l=1.35e-09 c=6.66667e-13 len=1
CTm tm 0 0.3p
RBSm tm bqm 22
LBm bqm bbm 0.8n
RLBm bqm bbm 100
Qm 0 bbm exm BFT92
LEm exm em 0.8n
RLEm exm em 100
REm vdd em 220
CEm em 0 0.5p
OT3m tm 0 um 0 lt_T3m
.model lt_T3m ltra r=0 g=0 l=1.35e-09 c=6.66667e-13 len=1
CUm um 0 1.9p
RONm um km 4.5
CKm km 0 1.8p
RTMm km 0 40.2
OT4m um 0 am 0 lt_T4m
.model lt_T4m ltra r=0 g=0 l=2.7e-09 c=1.33333e-12 len=1
CAm am 0 0.5p
RFm am fm 1
RFXm fm 0 1G
XRX ep em vdd ry rz lvds100
ORXP ry 0 ryf 0 lt_RXP
.model lt_RXP ltra r=0 g=0 l=2e-08 c=8e-12 len=1
ORXN rz 0 rzf 0 lt_RXN
.model lt_RXN ltra r=0 g=0 l=2e-08 c=8e-12 len=1
RRX ryf rzf 100
RA1sqa ep ipsqa 200
RB1sqa ipsqa 0 2000
RA2sqa em insqa 200
RB2sqa insqa vsq 2000
CPsqa ipsqa 0 0.3p
CNsqa insqa 0 0.3p
Xsqa ipsqa insqa vdd sqa tlv360x vos=0
RA1sqb em ipsqb 200
RB1sqb ipsqb 0 2000
RA2sqb ep insqb 200
RB2sqb insqb vsq 2000
CPsqb ipsqb 0 0.3p
CNsqb insqb 0 0.3p
Xsqb ipsqb insqb vdd sqb tlv360x vos=0
RA1dca ep ipdca 499
RB1dca ipdca 0 1000
RA2dca em indca 499
RB2dca indca vdisc 1000
CPdca ipdca 0 0.3p
CNdca indca 0 0.3p
Xdca ipdca indca vdd dca tlv360x vos=0
RA1dcb em ipdcb 499
RB1dcb ipdcb 0 1000
RA2dcb ep indcb 499
RB2dcb indcb vdisc 1000
CPdcb ipdcb 0 0.3p
CNdcb indcb 0 0.3p
Xdcb ipdcb indcb vdd dcb tlv360x vos=0
RATsqa sqa atsqa 150
Dsqa atsqa envs BAS70
RATsqb sqb atsqb 150
Dsqb atsqb envs BAS70
CEVenvs envs 0 6.8e-12
RDEenvs envs 0 1500
Xsqact envs veth vdd sqact tlv360x hys=30m
CLsqact sqact 0 3p
RATdca dca atdca 150
Ddca atdca envd BAS70
RATdcb dcb atdcb 150
Ddcb atdcb envd BAS70
CEVenvd envd 0 6.8e-12
RDEenvd envd 0 680
Xdcact envd veth vdd dcact tlv360x hys=30m
CLdcact dcact 0 3p
.tran 2e-11 6.86667e-07 0 2e-11
.control
set wr_singlescale
set wr_vecnames
option numdgt=7
run
wrdata /home/Projects/USB_60/AFE/Discrete/Receiver/sim/results/fs/wave.txt v(tp) v(tm) v(fp) v(fm) v(ep) v(em) v(ryf) v(rzf) v(sqa) v(sqb) v(envs) v(sqact) v(envd) v(dcact)
quit
.endc
.end
