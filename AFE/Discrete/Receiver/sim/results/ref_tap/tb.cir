* discrete USB HS receiver - generated by run_sims.py
.include /home/Projects/USB_60/AFE/Discrete/Receiver/sim/models/rx_models.lib
.options temp=27 tnom=27 reltol=1e-4 method=trap
VDD vdd 0 3.3
VSQ vsqs 0 1.32
RSQ vsqs vsq 1
CSQ vsq 0 100n
VDC vdcs 0 1.21
RDC vdcs vdisc 1
CDC vdisc 0 100n
RET1 vdd veth 18000
RET2 veth 0 10000
CET veth 0 100n
VSp sp 0 PWL( 0.00000e+00 0.00000 4.70833e-08 0.00000 4.77083e-08 0.80000 4.91667e-08 0.80000 4.97917e-08
+ 0.00000 5.12500e-08 0.00000 5.18750e-08 0.80000 5.33333e-08 0.80000 5.39583e-08 0.00000 5.54167e-08
+ 0.00000 5.60417e-08 0.80000 5.75000e-08 0.80000 5.81250e-08 0.00000 5.95833e-08 0.00000 6.02083e-08
+ 0.80000 6.16667e-08 0.80000 6.22917e-08 0.00000 6.37500e-08 0.00000 6.43750e-08 0.80000 6.58333e-08
+ 0.80000 6.64583e-08 0.00000 6.79167e-08 0.00000 6.85417e-08 0.80000 7.00000e-08 0.80000 7.06250e-08
+ 0.00000 7.20833e-08 0.00000 7.27083e-08 0.80000 7.41667e-08 0.80000 7.47917e-08 0.00000 7.62500e-08
+ 0.00000 7.68750e-08 0.80000 7.83333e-08 0.80000 7.89583e-08 0.00000 8.04167e-08 0.00000 8.10417e-08
+ 0.80000 8.25000e-08 0.80000 8.31250e-08 0.00000 8.45833e-08 0.00000 8.52083e-08 0.80000 8.66667e-08
+ 0.80000 8.72917e-08 0.00000 8.87500e-08 0.00000 8.93750e-08 0.80000 9.08333e-08 0.80000 9.14583e-08
+ 0.00000 9.29167e-08 0.00000 9.35417e-08 0.80000 9.50000e-08 0.80000 9.56250e-08 0.00000 9.70833e-08
+ 0.00000 9.77083e-08 0.80000 9.91667e-08 0.80000 9.97917e-08 0.00000 1.01250e-07 0.00000 1.01875e-07
+ 0.80000 1.03333e-07 0.80000 1.03958e-07 0.00000 1.05417e-07 0.00000 1.06042e-07 0.80000 1.07500e-07
+ 0.80000 1.08125e-07 0.00000 1.15833e-07 0.00000 1.16458e-07 0.80000 1.17917e-07 0.80000 1.18542e-07
+ 0.00000 1.20000e-07 0.00000 1.20625e-07 0.80000 1.22083e-07 0.80000 1.22708e-07 0.00000 1.28333e-07
+ 0.00000 1.28958e-07 0.80000 1.30417e-07 0.80000 1.31042e-07 0.00000 1.32500e-07 0.00000 1.33125e-07
+ 0.80000 1.34583e-07 0.80000 1.35208e-07 0.00000 1.36667e-07 0.00000 1.37292e-07 0.80000 1.38750e-07
+ 0.80000 1.39375e-07 0.00000 1.40833e-07 0.00000 1.41458e-07 0.80000 1.42917e-07 0.80000 1.43542e-07
+ 0.00000 1.45000e-07 0.00000 1.45625e-07 0.80000 1.47083e-07 0.80000 1.47708e-07 0.00000 1.49167e-07
+ 0.00000 1.49792e-07 0.80000 1.51250e-07 0.80000 1.51875e-07 0.00000 1.53333e-07 0.00000 1.53958e-07
+ 0.80000 1.55417e-07 0.80000 1.56042e-07 0.00000 1.57500e-07 0.00000 1.58125e-07 0.80000 1.59583e-07
+ 0.80000 1.60208e-07 0.00000 1.61667e-07 0.00000 1.62292e-07 0.80000 1.63750e-07 0.80000 1.64375e-07
+ 0.00000 1.65833e-07 0.00000 1.66458e-07 0.80000 1.67917e-07 0.80000 1.68542e-07 0.00000 1.70000e-07
+ 0.00000 1.70625e-07 0.80000 1.72083e-07 0.80000 1.72708e-07 0.00000 1.74167e-07 0.00000 1.74792e-07
+ 0.80000 1.76250e-07 0.80000 1.76875e-07 0.00000 1.78333e-07 0.00000 1.78958e-07 0.80000 1.80417e-07
+ 0.80000 1.81042e-07 0.00000 1.82500e-07 0.00000 1.83125e-07 0.80000 1.84583e-07 0.80000 1.85208e-07
+ 0.00000 1.86667e-07 0.00000 1.87292e-07 0.80000 1.88750e-07 0.80000 1.89375e-07 0.00000 1.90833e-07
+ 0.00000 1.91458e-07 0.80000 1.92917e-07 0.80000 1.93542e-07 0.00000 1.95000e-07 0.00000 1.95625e-07
+ 0.80000 1.97083e-07 0.80000 1.97708e-07 0.00000 1.99167e-07 0.00000 1.99792e-07 0.80000 2.01250e-07
+ 0.80000 2.01875e-07 0.00000 2.03333e-07 0.00000 2.03958e-07 0.80000 2.05417e-07 0.80000 2.06042e-07
+ 0.00000 2.07500e-07 0.00000 2.08125e-07 0.80000 2.09583e-07 0.80000 2.10208e-07 0.00000 2.11667e-07
+ 0.00000 2.12292e-07 0.80000 2.13750e-07 0.80000 2.14375e-07 0.00000 2.15833e-07 0.00000 2.16458e-07
+ 0.80000 2.17917e-07 0.80000 2.18542e-07 0.00000 2.20000e-07 0.00000 2.20625e-07 0.80000 2.22083e-07
+ 0.80000 2.22708e-07 0.00000 2.24167e-07 0.00000 2.24792e-07 0.80000 2.26250e-07 0.80000 2.26875e-07
+ 0.00000 2.28333e-07 0.00000 2.28958e-07 0.80000 2.30417e-07 0.80000 2.31042e-07 0.00000 2.32500e-07
+ 0.00000 2.33125e-07 0.80000 2.34583e-07 0.80000 2.35208e-07 0.00000 2.36667e-07 0.00000 2.37292e-07
+ 0.80000 2.38750e-07 0.80000 2.39375e-07 0.00000 2.40833e-07 0.00000 2.41458e-07 0.80000 2.42917e-07
+ 0.80000 2.43542e-07 0.00000 2.45000e-07 0.00000 2.45625e-07 0.80000 2.47083e-07 0.80000 2.47708e-07
+ 0.00000 2.49167e-07 0.00000 2.49792e-07 0.80000 2.51250e-07 0.80000 2.51875e-07 0.00000 2.53333e-07
+ 0.00000 2.53958e-07 0.80000 2.55417e-07 0.80000 2.56042e-07 0.00000 2.57500e-07 0.00000 2.58125e-07
+ 0.80000 2.59583e-07 0.80000 2.60208e-07 0.00000 2.61667e-07 0.00000 2.62292e-07 0.80000 2.63750e-07
+ 0.80000 2.64375e-07 0.00000 2.65833e-07 0.00000 2.66458e-07 0.80000 2.67917e-07 0.80000 2.68542e-07
+ 0.00000 2.70000e-07 0.00000 2.70625e-07 0.80000 2.72083e-07 0.80000 2.72708e-07 0.00000 2.74167e-07
+ 0.00000 2.74792e-07 0.80000 2.76250e-07 0.80000 2.76875e-07 0.00000 2.78333e-07 0.00000 2.78958e-07
+ 0.80000 2.82500e-07 0.80000 2.83125e-07 0.00000 2.86667e-07 0.00000 2.87292e-07 0.80000 2.90833e-07
+ 0.80000 2.91458e-07 0.00000 2.95000e-07 0.00000 2.95625e-07 0.80000 2.99167e-07 0.80000 2.99792e-07
+ 0.00000 3.03333e-07 0.00000 3.03958e-07 0.80000 3.07500e-07 0.80000 3.08125e-07 0.00000 3.11667e-07
+ 0.00000 3.12292e-07 0.80000 3.15833e-07 0.80000 3.16458e-07 0.00000 3.20000e-07 0.00000 3.20625e-07
+ 0.80000 3.24167e-07 0.80000 3.24792e-07 0.00000 3.28333e-07 0.00000 3.28958e-07 0.80000 3.32500e-07
+ 0.80000 3.33125e-07 0.00000 3.36667e-07 0.00000 3.37292e-07 0.80000 3.40833e-07 0.80000 3.41458e-07
+ 0.00000 3.45000e-07 0.00000 3.45625e-07 0.80000 3.49167e-07 0.80000 3.49792e-07 0.00000 3.53333e-07
+ 0.00000 3.53958e-07 0.80000 3.57500e-07 0.80000 3.58125e-07 0.00000 3.61667e-07 0.00000 3.62292e-07
+ 0.80000 3.65833e-07 0.80000 3.66458e-07 0.00000 3.70000e-07 0.00000 3.70625e-07 0.80000 3.74167e-07
+ 0.80000 3.74792e-07 0.00000 3.78333e-07 0.00000 3.78958e-07 0.80000 3.82500e-07 0.80000 3.83125e-07
+ 0.00000 3.86667e-07 0.00000 3.87292e-07 0.80000 3.90833e-07 0.80000 3.91458e-07 0.00000 3.95000e-07
+ 0.00000 3.95625e-07 0.80000 3.99167e-07 0.80000 3.99792e-07 0.00000 4.03333e-07 0.00000 4.03958e-07
+ 0.80000 4.07500e-07 0.80000 4.08125e-07 0.00000 4.11667e-07 0.00000 4.12292e-07 0.80000 4.20000e-07
+ 0.80000 4.20625e-07 0.00000 4.28333e-07 0.00000 4.28958e-07 0.80000 4.36667e-07 0.80000 4.37292e-07
+ 0.00000 4.45000e-07 0.00000 4.45625e-07 0.80000 4.53333e-07 0.80000 4.53958e-07 0.00000 4.61667e-07
+ 0.00000 4.62292e-07 0.80000 4.70000e-07 0.80000 4.70625e-07 0.00000 4.78333e-07 0.00000 4.78958e-07
+ 0.80000 4.86667e-07 0.80000 4.87292e-07 0.00000 4.95000e-07 0.00000 4.95625e-07 0.80000 5.03333e-07
+ 0.80000 5.03958e-07 0.00000 5.11667e-07 0.00000 5.12292e-07 0.80000 5.20000e-07 0.80000 5.20625e-07
+ 0.00000 5.28333e-07 0.00000 5.28958e-07 0.80000 5.36667e-07 0.80000 5.37292e-07 0.00000 5.45000e-07
+ 0.00000 5.45625e-07 0.80000 5.59583e-07 0.80000 5.60208e-07 0.00000 5.74167e-07 0.00000 5.74792e-07
+ 0.80000 5.88750e-07 0.80000 5.89375e-07 0.00000 6.03333e-07 0.00000 6.03958e-07 0.80000 6.17917e-07
+ 0.80000 6.18542e-07 0.00000 6.32500e-07 0.00000 6.33125e-07 0.80000 6.47083e-07 0.80000 6.47708e-07
+ 0.00000 6.61667e-07 0.00000 6.62292e-07 0.80000 6.76250e-07 0.80000 6.76875e-07 0.00000 6.90833e-07
+ 0.00000 6.91458e-07 0.80000 7.05417e-07 0.80000 7.06042e-07 0.00000 7.20000e-07 0.00000 7.20625e-07
+ 0.80000 7.34583e-07 0.80000 7.35208e-07 0.00000 7.49167e-07 0.00000 7.49792e-07 0.80000 7.63750e-07
+ 0.80000 7.64375e-07 0.00000 7.78333e-07 0.00000 7.78958e-07 0.80000 7.92917e-07 0.80000 7.93542e-07
+ 0.00000 7.95000e-07 0.00000 7.95625e-07 0.80000 8.09583e-07 0.80000 8.10208e-07 0.00000 8.11667e-07
+ 0.00000 8.12292e-07 0.80000 8.26250e-07 0.80000 8.26875e-07 0.00000 8.28333e-07 0.00000 8.28958e-07
+ 0.80000 8.42917e-07 0.80000 8.43542e-07 0.00000 8.45000e-07 0.00000 8.45625e-07 0.80000 8.59583e-07
+ 0.80000 8.60208e-07 0.00000 8.61667e-07 0.00000 8.62292e-07 0.80000 8.76250e-07 0.80000 8.76875e-07
+ 0.00000 8.78333e-07 0.00000 8.78958e-07 0.80000 8.92917e-07 0.80000 8.93542e-07 0.00000 8.95000e-07
+ 0.00000 8.95625e-07 0.80000 9.09583e-07 0.80000 9.10208e-07 0.00000 9.11667e-07 0.00000 9.12292e-07
+ 0.80000 9.13750e-07 0.80000 9.14375e-07 0.00000 9.28333e-07 0.00000 9.28958e-07 0.80000 9.30417e-07
+ 0.80000 9.31042e-07 0.00000 9.45000e-07 0.00000 9.45625e-07 0.80000 9.47083e-07 0.80000 9.47708e-07
+ 0.00000 9.61667e-07 0.00000 9.62292e-07 0.80000 9.63750e-07 0.80000 9.64375e-07 0.00000 9.78333e-07
+ 0.00000 9.78958e-07 0.80000 9.80417e-07 0.80000 9.81042e-07 0.00000 9.95000e-07 0.00000 9.95625e-07
+ 0.80000 9.97083e-07 0.80000 9.97708e-07 0.00000 1.01167e-06 0.00000 1.01229e-06 0.80000 1.01375e-06
+ 0.80000 1.01438e-06 0.00000 1.02833e-06 0.00000 1.02896e-06 0.80000 1.03042e-06 0.80000 1.03104e-06
+ 0.00000 1.04500e-06 0.00000 1.04563e-06 0.80000 1.04708e-06 0.80000 1.04771e-06 0.00000 1.06167e-06
+ 0.00000 1.06229e-06 0.80000 1.06375e-06 0.80000 1.06438e-06 0.00000 1.07833e-06 0.00000 1.07896e-06
+ 0.80000 1.08042e-06 0.80000 1.08104e-06 0.00000 1.08250e-06 0.00000 1.08313e-06 0.80000 1.08875e-06
+ 0.80000 1.08938e-06 0.00000 1.09500e-06 0.00000 1.09563e-06 0.80000 1.09917e-06 0.80000 1.09979e-06
+ 0.00000 1.10750e-06 0.00000 1.10813e-06 0.80000 1.10958e-06 0.80000 1.11021e-06 0.00000 1.11583e-06
+ 0.00000 1.11646e-06 0.80000 1.13250e-06 0.80000 1.13313e-06 0.00000)
RSp sp hp 45
CHp hp 0 2p
OCAp hp 0 bp 0 lt_CAp
.model lt_CAp ltra r=0 g=0 l=1.125e-07 c=5.55556e-11 len=1
CBp bp 0 0.5p
OT1p bp 0 xp 0 lt_T1p
.model lt_T1p ltra r=0 g=0 l=2.7e-09 c=1.33333e-12 len=1
CXp xp 0 0.85p
OT2p xp 0 tp 0 lt_T2p
.model lt_T2p ltra r=0 g=0 l=1.35e-09 c=6.66667e-13 len=1
CTp tp 0 0.3p
OT3p tp 0 up 0 lt_T3p
.model lt_T3p ltra r=0 g=0 l=1.35e-09 c=6.66667e-13 len=1
CUp up 0 1.9p
CKp up 0 1.8p
OT4p up 0 ap 0 lt_T4p
.model lt_T4p ltra r=0 g=0 l=2.7e-09 c=1.33333e-12 len=1
CAp ap 0 0.5p
OCDp ap 0 fp 0 lt_CDp
.model lt_CDp ltra r=0 g=0 l=1.125e-07 c=5.55556e-11 len=1
CFp fp 0 2p
RFp fp 0 45
VSm sm 0 PWL( 0.00000e+00 0.00000 4.50000e-08 0.00000 4.56250e-08 0.80000 4.70833e-08 0.80000 4.77083e-08
+ 0.00000 4.91667e-08 0.00000 4.97917e-08 0.80000 5.12500e-08 0.80000 5.18750e-08 0.00000 5.33333e-08
+ 0.00000 5.39583e-08 0.80000 5.54167e-08 0.80000 5.60417e-08 0.00000 5.75000e-08 0.00000 5.81250e-08
+ 0.80000 5.95833e-08 0.80000 6.02083e-08 0.00000 6.16667e-08 0.00000 6.22917e-08 0.80000 6.37500e-08
+ 0.80000 6.43750e-08 0.00000 6.58333e-08 0.00000 6.64583e-08 0.80000 6.79167e-08 0.80000 6.85417e-08
+ 0.00000 7.00000e-08 0.00000 7.06250e-08 0.80000 7.20833e-08 0.80000 7.27083e-08 0.00000 7.41667e-08
+ 0.00000 7.47917e-08 0.80000 7.62500e-08 0.80000 7.68750e-08 0.00000 7.83333e-08 0.00000 7.89583e-08
+ 0.80000 8.04167e-08 0.80000 8.10417e-08 0.00000 8.25000e-08 0.00000 8.31250e-08 0.80000 8.45833e-08
+ 0.80000 8.52083e-08 0.00000 8.66667e-08 0.00000 8.72917e-08 0.80000 8.87500e-08 0.80000 8.93750e-08
+ 0.00000 9.08333e-08 0.00000 9.14583e-08 0.80000 9.29167e-08 0.80000 9.35417e-08 0.00000 9.50000e-08
+ 0.00000 9.56250e-08 0.80000 9.70833e-08 0.80000 9.77083e-08 0.00000 9.91667e-08 0.00000 9.97917e-08
+ 0.80000 1.01250e-07 0.80000 1.01875e-07 0.00000 1.03333e-07 0.00000 1.03958e-07 0.80000 1.05417e-07
+ 0.80000 1.06042e-07 0.00000 1.07500e-07 0.00000 1.08125e-07 0.80000 1.15833e-07 0.80000 1.16458e-07
+ 0.00000 1.17917e-07 0.00000 1.18542e-07 0.80000 1.20000e-07 0.80000 1.20625e-07 0.00000 1.22083e-07
+ 0.00000 1.22708e-07 0.80000 1.28333e-07 0.80000 1.28958e-07 0.00000 1.30417e-07 0.00000 1.31042e-07
+ 0.80000 1.32500e-07 0.80000 1.33125e-07 0.00000 1.34583e-07 0.00000 1.35208e-07 0.80000 1.36667e-07
+ 0.80000 1.37292e-07 0.00000 1.38750e-07 0.00000 1.39375e-07 0.80000 1.40833e-07 0.80000 1.41458e-07
+ 0.00000 1.42917e-07 0.00000 1.43542e-07 0.80000 1.45000e-07 0.80000 1.45625e-07 0.00000 1.47083e-07
+ 0.00000 1.47708e-07 0.80000 1.49167e-07 0.80000 1.49792e-07 0.00000 1.51250e-07 0.00000 1.51875e-07
+ 0.80000 1.53333e-07 0.80000 1.53958e-07 0.00000 1.55417e-07 0.00000 1.56042e-07 0.80000 1.57500e-07
+ 0.80000 1.58125e-07 0.00000 1.59583e-07 0.00000 1.60208e-07 0.80000 1.61667e-07 0.80000 1.62292e-07
+ 0.00000 1.63750e-07 0.00000 1.64375e-07 0.80000 1.65833e-07 0.80000 1.66458e-07 0.00000 1.67917e-07
+ 0.00000 1.68542e-07 0.80000 1.70000e-07 0.80000 1.70625e-07 0.00000 1.72083e-07 0.00000 1.72708e-07
+ 0.80000 1.74167e-07 0.80000 1.74792e-07 0.00000 1.76250e-07 0.00000 1.76875e-07 0.80000 1.78333e-07
+ 0.80000 1.78958e-07 0.00000 1.80417e-07 0.00000 1.81042e-07 0.80000 1.82500e-07 0.80000 1.83125e-07
+ 0.00000 1.84583e-07 0.00000 1.85208e-07 0.80000 1.86667e-07 0.80000 1.87292e-07 0.00000 1.88750e-07
+ 0.00000 1.89375e-07 0.80000 1.90833e-07 0.80000 1.91458e-07 0.00000 1.92917e-07 0.00000 1.93542e-07
+ 0.80000 1.95000e-07 0.80000 1.95625e-07 0.00000 1.97083e-07 0.00000 1.97708e-07 0.80000 1.99167e-07
+ 0.80000 1.99792e-07 0.00000 2.01250e-07 0.00000 2.01875e-07 0.80000 2.03333e-07 0.80000 2.03958e-07
+ 0.00000 2.05417e-07 0.00000 2.06042e-07 0.80000 2.07500e-07 0.80000 2.08125e-07 0.00000 2.09583e-07
+ 0.00000 2.10208e-07 0.80000 2.11667e-07 0.80000 2.12292e-07 0.00000 2.13750e-07 0.00000 2.14375e-07
+ 0.80000 2.15833e-07 0.80000 2.16458e-07 0.00000 2.17917e-07 0.00000 2.18542e-07 0.80000 2.20000e-07
+ 0.80000 2.20625e-07 0.00000 2.22083e-07 0.00000 2.22708e-07 0.80000 2.24167e-07 0.80000 2.24792e-07
+ 0.00000 2.26250e-07 0.00000 2.26875e-07 0.80000 2.28333e-07 0.80000 2.28958e-07 0.00000 2.30417e-07
+ 0.00000 2.31042e-07 0.80000 2.32500e-07 0.80000 2.33125e-07 0.00000 2.34583e-07 0.00000 2.35208e-07
+ 0.80000 2.36667e-07 0.80000 2.37292e-07 0.00000 2.38750e-07 0.00000 2.39375e-07 0.80000 2.40833e-07
+ 0.80000 2.41458e-07 0.00000 2.42917e-07 0.00000 2.43542e-07 0.80000 2.45000e-07 0.80000 2.45625e-07
+ 0.00000 2.47083e-07 0.00000 2.47708e-07 0.80000 2.49167e-07 0.80000 2.49792e-07 0.00000 2.51250e-07
+ 0.00000 2.51875e-07 0.80000 2.53333e-07 0.80000 2.53958e-07 0.00000 2.55417e-07 0.00000 2.56042e-07
+ 0.80000 2.57500e-07 0.80000 2.58125e-07 0.00000 2.59583e-07 0.00000 2.60208e-07 0.80000 2.61667e-07
+ 0.80000 2.62292e-07 0.00000 2.63750e-07 0.00000 2.64375e-07 0.80000 2.65833e-07 0.80000 2.66458e-07
+ 0.00000 2.67917e-07 0.00000 2.68542e-07 0.80000 2.70000e-07 0.80000 2.70625e-07 0.00000 2.72083e-07
+ 0.00000 2.72708e-07 0.80000 2.74167e-07 0.80000 2.74792e-07 0.00000 2.76250e-07 0.00000 2.76875e-07
+ 0.80000 2.78333e-07 0.80000 2.78958e-07 0.00000 2.82500e-07 0.00000 2.83125e-07 0.80000 2.86667e-07
+ 0.80000 2.87292e-07 0.00000 2.90833e-07 0.00000 2.91458e-07 0.80000 2.95000e-07 0.80000 2.95625e-07
+ 0.00000 2.99167e-07 0.00000 2.99792e-07 0.80000 3.03333e-07 0.80000 3.03958e-07 0.00000 3.07500e-07
+ 0.00000 3.08125e-07 0.80000 3.11667e-07 0.80000 3.12292e-07 0.00000 3.15833e-07 0.00000 3.16458e-07
+ 0.80000 3.20000e-07 0.80000 3.20625e-07 0.00000 3.24167e-07 0.00000 3.24792e-07 0.80000 3.28333e-07
+ 0.80000 3.28958e-07 0.00000 3.32500e-07 0.00000 3.33125e-07 0.80000 3.36667e-07 0.80000 3.37292e-07
+ 0.00000 3.40833e-07 0.00000 3.41458e-07 0.80000 3.45000e-07 0.80000 3.45625e-07 0.00000 3.49167e-07
+ 0.00000 3.49792e-07 0.80000 3.53333e-07 0.80000 3.53958e-07 0.00000 3.57500e-07 0.00000 3.58125e-07
+ 0.80000 3.61667e-07 0.80000 3.62292e-07 0.00000 3.65833e-07 0.00000 3.66458e-07 0.80000 3.70000e-07
+ 0.80000 3.70625e-07 0.00000 3.74167e-07 0.00000 3.74792e-07 0.80000 3.78333e-07 0.80000 3.78958e-07
+ 0.00000 3.82500e-07 0.00000 3.83125e-07 0.80000 3.86667e-07 0.80000 3.87292e-07 0.00000 3.90833e-07
+ 0.00000 3.91458e-07 0.80000 3.95000e-07 0.80000 3.95625e-07 0.00000 3.99167e-07 0.00000 3.99792e-07
+ 0.80000 4.03333e-07 0.80000 4.03958e-07 0.00000 4.07500e-07 0.00000 4.08125e-07 0.80000 4.11667e-07
+ 0.80000 4.12292e-07 0.00000 4.20000e-07 0.00000 4.20625e-07 0.80000 4.28333e-07 0.80000 4.28958e-07
+ 0.00000 4.36667e-07 0.00000 4.37292e-07 0.80000 4.45000e-07 0.80000 4.45625e-07 0.00000 4.53333e-07
+ 0.00000 4.53958e-07 0.80000 4.61667e-07 0.80000 4.62292e-07 0.00000 4.70000e-07 0.00000 4.70625e-07
+ 0.80000 4.78333e-07 0.80000 4.78958e-07 0.00000 4.86667e-07 0.00000 4.87292e-07 0.80000 4.95000e-07
+ 0.80000 4.95625e-07 0.00000 5.03333e-07 0.00000 5.03958e-07 0.80000 5.11667e-07 0.80000 5.12292e-07
+ 0.00000 5.20000e-07 0.00000 5.20625e-07 0.80000 5.28333e-07 0.80000 5.28958e-07 0.00000 5.36667e-07
+ 0.00000 5.37292e-07 0.80000 5.45000e-07 0.80000 5.45625e-07 0.00000 5.59583e-07 0.00000 5.60208e-07
+ 0.80000 5.74167e-07 0.80000 5.74792e-07 0.00000 5.88750e-07 0.00000 5.89375e-07 0.80000 6.03333e-07
+ 0.80000 6.03958e-07 0.00000 6.17917e-07 0.00000 6.18542e-07 0.80000 6.32500e-07 0.80000 6.33125e-07
+ 0.00000 6.47083e-07 0.00000 6.47708e-07 0.80000 6.61667e-07 0.80000 6.62292e-07 0.00000 6.76250e-07
+ 0.00000 6.76875e-07 0.80000 6.90833e-07 0.80000 6.91458e-07 0.00000 7.05417e-07 0.00000 7.06042e-07
+ 0.80000 7.20000e-07 0.80000 7.20625e-07 0.00000 7.34583e-07 0.00000 7.35208e-07 0.80000 7.49167e-07
+ 0.80000 7.49792e-07 0.00000 7.63750e-07 0.00000 7.64375e-07 0.80000 7.78333e-07 0.80000 7.78958e-07
+ 0.00000 7.92917e-07 0.00000 7.93542e-07 0.80000 7.95000e-07 0.80000 7.95625e-07 0.00000 8.09583e-07
+ 0.00000 8.10208e-07 0.80000 8.11667e-07 0.80000 8.12292e-07 0.00000 8.26250e-07 0.00000 8.26875e-07
+ 0.80000 8.28333e-07 0.80000 8.28958e-07 0.00000 8.42917e-07 0.00000 8.43542e-07 0.80000 8.45000e-07
+ 0.80000 8.45625e-07 0.00000 8.59583e-07 0.00000 8.60208e-07 0.80000 8.61667e-07 0.80000 8.62292e-07
+ 0.00000 8.76250e-07 0.00000 8.76875e-07 0.80000 8.78333e-07 0.80000 8.78958e-07 0.00000 8.92917e-07
+ 0.00000 8.93542e-07 0.80000 8.95000e-07 0.80000 8.95625e-07 0.00000 9.09583e-07 0.00000 9.10208e-07
+ 0.80000 9.11667e-07 0.80000 9.12292e-07 0.00000 9.13750e-07 0.00000 9.14375e-07 0.80000 9.28333e-07
+ 0.80000 9.28958e-07 0.00000 9.30417e-07 0.00000 9.31042e-07 0.80000 9.45000e-07 0.80000 9.45625e-07
+ 0.00000 9.47083e-07 0.00000 9.47708e-07 0.80000 9.61667e-07 0.80000 9.62292e-07 0.00000 9.63750e-07
+ 0.00000 9.64375e-07 0.80000 9.78333e-07 0.80000 9.78958e-07 0.00000 9.80417e-07 0.00000 9.81042e-07
+ 0.80000 9.95000e-07 0.80000 9.95625e-07 0.00000 9.97083e-07 0.00000 9.97708e-07 0.80000 1.01167e-06
+ 0.80000 1.01229e-06 0.00000 1.01375e-06 0.00000 1.01438e-06 0.80000 1.02833e-06 0.80000 1.02896e-06
+ 0.00000 1.03042e-06 0.00000 1.03104e-06 0.80000 1.04500e-06 0.80000 1.04563e-06 0.00000 1.04708e-06
+ 0.00000 1.04771e-06 0.80000 1.06167e-06 0.80000 1.06229e-06 0.00000 1.06375e-06 0.00000 1.06438e-06
+ 0.80000 1.07833e-06 0.80000 1.07896e-06 0.00000 1.08042e-06 0.00000 1.08104e-06 0.80000 1.08250e-06
+ 0.80000 1.08313e-06 0.00000 1.08875e-06 0.00000 1.08938e-06 0.80000 1.09500e-06 0.80000 1.09563e-06
+ 0.00000 1.09917e-06 0.00000 1.09979e-06 0.80000 1.10750e-06 0.80000 1.10813e-06 0.00000 1.10958e-06
+ 0.00000 1.11021e-06 0.80000 1.11583e-06 0.80000 1.11646e-06 0.00000)
RSm sm hm 45
CHm hm 0 2p
OCAm hm 0 bm 0 lt_CAm
.model lt_CAm ltra r=0 g=0 l=1.125e-07 c=5.55556e-11 len=1
CBm bm 0 0.5p
OT1m bm 0 xm 0 lt_T1m
.model lt_T1m ltra r=0 g=0 l=2.7e-09 c=1.33333e-12 len=1
CXm xm 0 0.85p
OT2m xm 0 tm 0 lt_T2m
.model lt_T2m ltra r=0 g=0 l=1.35e-09 c=6.66667e-13 len=1
CTm tm 0 0.3p
OT3m tm 0 um 0 lt_T3m
.model lt_T3m ltra r=0 g=0 l=1.35e-09 c=6.66667e-13 len=1
CUm um 0 1.9p
CKm um 0 1.8p
OT4m um 0 am 0 lt_T4m
.model lt_T4m ltra r=0 g=0 l=2.7e-09 c=1.33333e-12 len=1
CAm am 0 0.5p
OCDm am 0 fm 0 lt_CDm
.model lt_CDm ltra r=0 g=0 l=1.125e-07 c=5.55556e-11 len=1
CFm fm 0 2p
RFm fm 0 45
Vep ep 0 0
Vem em 0 0
Vryf ryf 0 0
Vrzf rzf 0 0
Vsqa sqa 0 0
Vsqb sqb 0 0
Venvs envs 0 0
Vsqact sqact 0 0
Venvd envd 0 0
Vdcact dcact 0 0
.tran 5e-12 1.1825e-06 0 5e-12
.control
set wr_singlescale
set wr_vecnames
option numdgt=7
run
wrdata /home/Projects/USB_60/AFE/Discrete/Receiver/sim/results/ref_tap/wave.txt v(tp) v(tm) v(fp) v(fm) v(ep) v(em) v(ryf) v(rzf) v(sqa) v(sqb) v(envs) v(sqact) v(envd) v(dcact)
quit
.endc
.end
