* discrete CDR board - loop transient - generated by run_sims.py
.include /home/Projects/USB_60/AFE/Discrete/CDR/sim/models/cdr_models.lib
.options temp=27 tnom=27 reltol=0.0001 method=gear maxord=2
VCC vcc 0 4.82
V5 v5 0 5
RC1 vcc c1 22
CC1 c1 0 100p
RB1b vcc x 4700
RB1a x b1 4700
RB2 b1 0 6800
XQ3 c1 b1 e1 BFR93A
RE1 e1 0 180
C1 b1 e1 1e-11
C2 e1 0 1e-11
Ccpl b1 t 3.3e-12
XL1 t lg LQW18_6N2
Llg lg 0 0.3n
Cpar t 0 0.6p
CP0 t 0 3e-13
Cs t k 1.8e-11
XD1 0 k SV305
Rk vk k 2200
VK vk 0 3.18
Cf t f 1.2e-11
XD2 a2 f SV305
VA a2 0 2.6
XL2 f pq LQW18_47N
Rpq pq p 0.5
RL v5 p 62
Cpp p 0 1.5p
RBU1 upn upn_b 47
RBU2 upp upp_b 47
RBD1 dnp dnp_b 47
RBD2 dnn dnn_b 47
XQ5 p upn_b eu BFR93A
XQ6 v5 upp_b eu BFR93A
RTU eu 0 100
XQ7 p dnp_b ed BFR93A
XQ8 v5 dnn_b ed BFR93A
RTD ed 0 100
CEU eu 0 0.5p
CED ed 0 0.5p
Cb2 e1 b2 1.5e-12
RB3 vcc b2 10000
RB4 b2 0 4700
XQ4 c2 b2 e2 BFR93A
RE2 e2 0 100
CE2 e2 0 100p
RC2 vcc c2 100
Cout c2 inp 100p
Rin inp vrf 50
VRF vrf 0 1.875
Cin inp 0 1.0p
Rtap c2 sma 470
Rsma sma 0 50
VDAT dat 0 PWL(0 1 4.112249e-07 1 4.113749e-07 0 4.133047e-07 0 4.134547e-07 1 4.153845e-07 1 4.155345e-07 0 4.174643e-07 0 4.176143e-07 1 4.195441e-07 1 4.196941e-07 0 4.216239e-07 0 4.217739e-07 1 4.237038e-07 1 4.238538e-07 0 4.257836e-07 0 4.259336e-07 1 4.278634e-07 1 4.280134e-07 0 4.299432e-07 0 4.300932e-07 1 4.320230e-07 1 4.321730e-07 0 4.341028e-07 0 4.342528e-07 1 4.361826e-07 1 4.363326e-07 0 4.382624e-07 0 4.384124e-07 1 4.403423e-07 1 4.404923e-07 0 4.424221e-07 0 4.425721e-07 1 4.445019e-07 1 4.446519e-07 0 4.465817e-07 0 4.467317e-07 1 4.486615e-07 1 4.488115e-07 0 4.507413e-07 0 4.508913e-07 1 4.528211e-07 1 4.529711e-07 0 4.549009e-07 0 4.550509e-07 1 4.569808e-07 1 4.571308e-07 0 4.590606e-07 0 4.592106e-07 1 4.611404e-07 1 4.612904e-07 0 4.632202e-07 0 4.633702e-07 1 4.653000e-07 1 4.654500e-07 0 4.673798e-07 0 4.675298e-07 1 4.694596e-07 1 4.696096e-07 0 4.715394e-07 0 4.716894e-07 1 4.736193e-07 1 4.737693e-07 0 4.819385e-07 0 4.820885e-07 1 4.840183e-07 1 4.841683e-07 0 4.860981e-07 0 4.862481e-07 1 4.881779e-07 1 4.883279e-07 0 4.902578e-07 0 4.904078e-07 1 4.923376e-07 1 4.924876e-07 0 4.964972e-07 0 4.966472e-07 1 4.985770e-07 1 4.987270e-07 0 5.006568e-07 0 5.008068e-07 1 5.027366e-07 1 5.028866e-07 0 5.048164e-07 0 5.049664e-07 1 5.110559e-07 1 5.112059e-07 0 5.131357e-07 0 5.132857e-07 1 5.152155e-07 1 5.153655e-07 0 5.172953e-07 0 5.174453e-07 1 5.214549e-07 1 5.216049e-07 0 5.256146e-07 0 5.257646e-07 1 5.276944e-07 1 5.278444e-07 0 5.297742e-07 0 5.299242e-07 1 5.401733e-07 1 5.403233e-07 0 5.422531e-07 0 5.424031e-07 1 5.464127e-07 1 5.465627e-07 0 5.484925e-07 0 5.486425e-07 1 5.505723e-07 1 5.507223e-07 0 5.547319e-07 0 5.548819e-07 1 5.609714e-07 1 5.611214e-07 0 5.630512e-07 0 5.632012e-07 1 5.713704e-07 1 5.715204e-07 0 5.755301e-07 0 5.756801e-07 1 5.796897e-07 1 5.798397e-07 0 5.817695e-07 0 5.819195e-07 1 5.942484e-07 1 5.943984e-07 0 5.984080e-07 0 5.985580e-07 1 6.004878e-07 1 6.006378e-07 0 6.025676e-07 0 6.027176e-07 1)
Adat [dat] [datd] adc1
.model adc1 adc_bridge(in_low=0.45 in_high=0.55 rise_delay=1e-12 fall_delay=1e-12)
Bcmp cmp 0 V=0.5 + 0.5 * tanh((V(inp) - 1.875) / 0.01)
Ack [cmp] [ck0] adc1
Ackb ck0 ck nbuf
.model nbuf d_buffer(rise_delay=4.5e-10 fall_delay=4.5e-10)
Ackn ck ckn ninv
.model ninv d_inverter(rise_delay=1e-12 fall_delay=1e-12)
Aen [en0] [enn] adc1
VEN en0 0 PWL(0 0 1e-08 0 1.1e-08 1)
Aseti enn setn ninv
Ahi hi pu1
.model pu1 d_pullup
Alo lo pd1
.model pd1 d_pulldown
.model ff d_dff(clk_delay=4.2e-10 set_delay=4.2e-10 reset_delay=4.2e-10 rise_delay=1e-12 fall_delay=1e-12)
Aff1 datd ck setn lo qa qan ff
Aff2 datd ckn setn lo qtp qtpn ff
Aff3 qa ck setn lo qb qbn ff
Aff4 qtp ck setn lo qt qtn ff
.model xr d_xor(rise_delay=3.3e-10 fall_delay=3.3e-10)
Aup [qb qt] up xr
Adn [qt qa] dn xr
.model dac1 dac_bridge(out_low=0 out_high=1 t_rise=200p t_fall=200p)
Aua [up dn qa ck] [upa dna qaa cka] dac1
BUP upp 0 V=1.49 + 0.8 * V(upa)
BUN upn 0 V=2.29 - 0.8 * V(upa)
BDP dnp 0 V=1.49 + 0.8 * V(dna)
BDN dnn 0 V=2.29 - 0.8 * V(dna)
Ikick 0 t PULSE(0 1m 1n 0.2n 0.2n 0.5n 1)
.save v(cka) v(qaa) v(f) v(upa) v(dna)
.tran 10p 6.60877e-07 0 10p
.control
run
linearize v(cka) v(qaa) v(f) v(upa) v(dna)
wrdata /home/Projects/USB_60/AFE/Discrete/CDR/sim/results/lock_5/wave.txt v(cka) v(qaa) v(f) v(upa) v(dna)
.endc
.end
