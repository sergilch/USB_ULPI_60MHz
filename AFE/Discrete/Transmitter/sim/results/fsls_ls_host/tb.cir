* discrete FS/LS driver - generated by run_fsls.py
.include /home/Projects/USB_60/AFE/Discrete/Transmitter/sim/models/tx_models.lib
.model RB751S40 D (is=8n n=1.03 rs=3.5 cjo=2.6p vj=0.35 m=0.45 bv=40 ibv=10u eg=0.69 xti=2)
.model BAT54WS D (is=20n n=1.03 rs=1.6 cjo=10p vj=0.33 m=0.45 bv=30 ibv=10u eg=0.69 xti=2)
.model NX3008N VDMOS (vto=1.03 kp=1.011 rd=0.715 rs=0.05 lambda=0.01
+ cgs=110p cgdmax=12p cgdmin=1.6p a=1.0 cjo=14p vj=0.7 m=0.4 is=1e-12 n=1.1 rb=0.3
+ tcvth=0.0022 mu=-1.5 ksubthres=0.1)
.model NX3008P VDMOS (pchan vto=-0.92 kp=0.1415 rd=0.826 rs=0.05 lambda=0.01
+ cgs=105p cgdmax=14p cgdmin=1.7p a=1.0 cjo=14p vj=0.7 m=0.4 is=1e-12 n=1.1 rb=0.3
+ tcvth=0.0022 mu=-1.5 ksubthres=0.1)
.options temp=27 tnom=27 reltol=1e-4 method=gear
VDD vdd 0 3.3
VDRV vdd vdrv 0
.model SWFS SW (vt=0.5 vh=0.05 ron=4.5 roff=1e9)
VSWC swc 0 PWL(0.00000e+00 0)
VLgpp lgpp 0 PWL( 0.00000e+00 3.3000)
ROgpp lgpp xgpp 25
RLSgpp xgpp gpp 1200
CKgpp xgpp gpp 1e-11
DHgpp xgpp gpp BAT54WS
CMgpp dp gpp 8.2e-12
CM2gpp dp m2gpp 4.7e-11
RM2gpp m2gpp gpp 470
VLgnp lgnp 0 PWL( 0.00000e+00 0.0000)
ROgnp lgnp xgnp 25
RLSgnp xgnp gnp 560
DHgnp gnp xgnp BAT54WS
CMgnp dp gnp 1.5e-10
MPp pdp gpp vdrv NX3008P
VDPp pdp dp 0
MNp ndp gnp 0 NX3008N
VDNp dp ndp 0
CPDp dp 0 1p
RSp dp s1p 33
CS1p s1p 0 1.8p
SWp s1p lp swc 0 SWFS
CSWp lp 0 1.9p
VBp btp 0 1.69
RBTp btp bbp 50
RBBp bbp bqp 68
QHp chp bqp nem BFT92
CCHp chp 0 0.3p
DBp chp lp RB751S40
CTXp lp 0 6.8p
CDp lp 0 1.0p
CESDp lp 0 2.5p
CLp lp 0 5e-11
VLgpm lgpm 0 PWL( 0.00000e+00 3.3000)
ROgpm lgpm xgpm 25
RLSgpm xgpm gpm 1200
CKgpm xgpm gpm 1e-11
DHgpm xgpm gpm BAT54WS
CMgpm dm gpm 8.2e-12
CM2gpm dm m2gpm 4.7e-11
RM2gpm m2gpm gpm 470
VLgnm lgnm 0 PWL( 0.00000e+00 0.0000)
ROgnm lgnm xgnm 25
RLSgnm xgnm gnm 560
DHgnm gnm xgnm BAT54WS
CMgnm dm gnm 1.5e-10
MPm pdm gpm vdrv NX3008P
VDPm pdm dm 0
MNm ndm gnm 0 NX3008N
VDNm dm ndm 0
CPDm dm 0 1p
RSm dm s1m 33
CS1m s1m 0 1.8p
SWm s1m lm swc 0 SWFS
CSWm lm 0 1.9p
VBm btm 0 2.28
RBTm btm bbm 50
RBBm bbm bqm 68
QHm chm bqm nem BFT92
CCHm chm 0 0.3p
DBm chm lm RB751S40
CTXm lm 0 6.8p
CDm lm 0 1.0p
CESDm lm 0 2.5p
CLm lm 0 5e-11
IT vdd nem 0.0189
VBD bd 0 0.60
QD 0 bd nem BFT92
RPUD vpu lm 1500
VPU vpu 0 3.3
RPDP lp 0 15003
RPDM lm 0 15003
VHOp hop 0 PWL(0.00000e+00 0.0000 4.10000e-06 0.0000 4.20000e-06 3.3000 4.76667e-06 3.3000 4.86667e-06 0.0000 5.43333e-06 0.0000 5.53333e-06 3.3000 6.10000e-06 3.3000 6.20000e-06 0.0000 6.76667e-06 0.0000 6.86667e-06 3.3000 7.43333e-06 3.3000 7.53333e-06 0.0000 8.10000e-06 0.0000 8.20000e-06 3.3000 1.07667e-05 3.3000 1.08667e-05 0.0000 1.14333e-05 0.0000 1.15333e-05 3.3000 1.21000e-05 3.3000 1.22000e-05 0.0000 1.27667e-05 0.0000 1.28667e-05 3.3000 1.47667e-05 3.3000 1.48667e-05 0.0000 1.54333e-05 0.0000 1.55333e-05 3.3000 1.61000e-05 3.3000 1.62000e-05 0.0000 1.67667e-05 0.0000 1.68667e-05 3.3000 1.74333e-05 3.3000 1.75333e-05 0.0000 1.81000e-05 0.0000 1.82000e-05 3.3000 1.87667e-05 3.3000 1.88667e-05 0.0000 1.94333e-05 0.0000 1.95333e-05 3.3000 2.41000e-05 3.3000 2.42000e-05 0.0000 2.61000e-05 0.0000 2.62000e-05 3.3000 2.74333e-05 3.3000 2.75333e-05 0.0000 2.94333e-05 0.0000 2.95333e-05 3.3000 3.07667e-05 3.3000 3.08667e-05 0.0000 3.41000e-05 0.0000 3.42000e-05 3.3000 3.47667e-05 3.3000 3.48667e-05 0.0000 3.61000e-05 0.0000 3.62000e-05 3.3000 3.67667e-05 3.3000 3.68667e-05 0.0000 3.74333e-05 0.0000 3.75333e-05 3.3000 3.87667e-05 3.3000 3.88667e-05 0.0000)
RHOp hop lp 36
VHOm hom 0 PWL(0.00000e+00 3.3000 4.10000e-06 3.3000 4.20000e-06 0.0000 4.76667e-06 0.0000 4.86667e-06 3.3000 5.43333e-06 3.3000 5.53333e-06 0.0000 6.10000e-06 0.0000 6.20000e-06 3.3000 6.76667e-06 3.3000 6.86667e-06 0.0000 7.43333e-06 0.0000 7.53333e-06 3.3000 8.10000e-06 3.3000 8.20000e-06 0.0000 1.07667e-05 0.0000 1.08667e-05 3.3000 1.14333e-05 3.3000 1.15333e-05 0.0000 1.21000e-05 0.0000 1.22000e-05 3.3000 1.27667e-05 3.3000 1.28667e-05 0.0000 1.47667e-05 0.0000 1.48667e-05 3.3000 1.54333e-05 3.3000 1.55333e-05 0.0000 1.61000e-05 0.0000 1.62000e-05 3.3000 1.67667e-05 3.3000 1.68667e-05 0.0000 1.74333e-05 0.0000 1.75333e-05 3.3000 1.81000e-05 3.3000 1.82000e-05 0.0000 1.87667e-05 0.0000 1.88667e-05 3.3000 1.94333e-05 3.3000 1.95333e-05 0.0000 2.41000e-05 0.0000 2.42000e-05 3.3000 2.61000e-05 3.3000 2.62000e-05 0.0000 2.74333e-05 0.0000 2.75333e-05 3.3000 2.94333e-05 3.3000 2.95333e-05 0.0000 3.07667e-05 0.0000 3.08667e-05 3.3000 3.41000e-05 3.3000 3.42000e-05 0.0000 3.47667e-05 0.0000 3.48667e-05 3.3000 3.61000e-05 3.3000 3.62000e-05 0.0000 3.67667e-05 0.0000 3.68667e-05 3.3000 3.74333e-05 3.3000 3.75333e-05 0.0000 3.87667e-05 0.0000 3.88667e-05 3.3000 4.21000e-05 3.3000 4.22000e-05 0.0000 4.34333e-05 0.0000 4.35333e-05 3.3000)
RHOm hom lm 36
RRTp vdd rrp 13000
RRBp rrp 0 10000
RRFp cop rrp 82000
RRXp lp rxp 1k
CRXp rxp 0 4p
BCp cip 0 V=3.3*(0.5+0.5*tanh(400*(v(rrp)-v(rxp))))
RCOp cip cop 50
CCOp cop 0 20p
RRTm vdd rrm 13000
RRBm rrm 0 10000
RRFm com rrm 82000
RRXm lm rxm 1k
CRXm rxm 0 4p
BCm cim 0 V=3.3*(0.5+0.5*tanh(400*(v(rrm)-v(rxm))))
RCOm cim com 50
CCOm com 0 20p
BCR cir 0 V=3.3*(0.5+0.5*tanh(400*(v(rxm)-v(rxp))))
RCOR cir cor 50
CCOR cor 0 20p
.tran 4e-10 4.81e-05 0 1.6e-09
.control
set wr_singlescale
set wr_vecnames
option numdgt=6
run
wrdata /home/Projects/USB_60/AFE/Discrete/Transmitter/sim/results/fsls_ls_host/wave.txt v(lp) v(lm) v(dp) v(dm) v(gpp) v(gnp) v(gpm) v(gnm) i(vdpp) i(vdnp) i(vdpm) i(vdnm) v(cop) v(com) v(cor) i(vdrv) v(lgpp) v(lgnp) v(lgpm) v(lgnm)
quit
.endc
.end
