* discrete USB HS transmitter core - generated by run_sims.py
.include /home/Projects/USB_60/AFE/Discrete/Transmitter/sim/models/tx_models.lib
.model RB751S40 D (is=8n n=1.03 rs=3.5 cjo=2.6p vj=0.35 m=0.45 bv=40 ibv=10u eg=0.69 xti=2)
.options temp=-40 tnom=27 reltol=1e-4 method=trap
VDD vdd 0 3.465
VCTL vctl 0 0.6
XU1B vctl eg og vdd opamp_rr
RBG og bg 1k
QG vrefn bg eg Q2N3904
RG eg 0 3570
RR vdd vrefn 1690
CR vdd vrefn 100n
XU1A vrefn et ot vdd opamp_rr
RBT ot bt 1k
CBT bt vdd 10n
RS vdd et 15
QT nem bt et Q2N3906
CNE nem 0 0.5p
QP cp bpq nem BFT92
QN cn bnq nem BFT92
QD cd bdi nem BFT92
VIP cp cpl 0
VIN cn cnl 0
VID cd 0 0
CCP cpl 0 0.15p
CCN cnl 0 0.15p
DBP cpl cpk RB751S40
DBN cnl cnk RB751S40
LCP cpk dpi 0.8n
RLCP cpk dpi 50
RLCN cnk dmi 50
LCN cnk dmi 0.8n
VPEp pep 0 PWL( 0.0000e+00 1.8550 3.1167e-07 1.8550 3.1187e-07 2.4450 5.2000e-07 2.4450 5.2020e-07 1.8550
+ 6.4500e-07 1.8550 6.4520e-07 2.4450 7.7000e-07 2.4450 7.7020e-07 1.8550)
RPEp pep bpx 7
OPEp bpx 0 bpi 0 lt_PEp
.model lt_PEp ltra r=0 g=0 l=3e-09 c=1.2e-12 len=1
RTUp vdd bpi 130
RTDp bpi 0 82
RBSp bpi bpq 68
VPEn pen 0 PWL( 0.0000e+00 2.4450 3.1167e-07 2.4450 3.1187e-07 1.8550 6.4500e-07 1.8550 6.4520e-07 2.4450)
RPEn pen bnx 7
OPEn bnx 0 bni 0 lt_PEn
.model lt_PEn ltra r=0 g=0 l=3e-09 c=1.2e-12 len=1
RTUn vdd bni 130
RTDn bni 0 82
RBSn bni bnq 68
VEN en 0 PWL( 0.0000e+00 0.0000 1.0333e-07 0.0000 1.0433e-07 3.4650 8.9500e-07 3.4650 8.9600e-07 0.0000)
REN en en3 25
RA en3 bdi 237
RB bdi 0 255
RC vdd bdi 549
CBD bdi 0 1p
CDp dpi 0 1.0p
RCAPp dpi xcp 0.5
CCAPp xcp 0 6.8e-12
CSWp dpi 0 1.9p
RRXp dpi rxp 1k
CRXp rxp 0 4p
RONp dpi s2p 4.5
CS2p s2p 0 1.8p
RTMp s2p 0 40.2
OTRp dpi 0 np 0 lt_TRp
.model lt_TRp ltra r=0 g=0 l=2.25e-09 c=1.11111e-12 len=1
CESDp np 0 2.5p
OCBp np 0 fp 0 lt_CBp
.model lt_CBp ltra r=0 g=0 l=1.125e-07 c=5.55556e-11 len=1
CHSTp fp 0 2p
RHSTp fp 0 45
CDm dmi 0 1.0p
RCAPm dmi xcm 0.5
CCAPm xcm 0 6.8e-12
CSWm dmi 0 1.9p
RRXm dmi rxm 1k
CRXm rxm 0 4p
RONm dmi s2m 4.5
CS2m s2m 0 1.8p
RTMm s2m 0 40.2
OTRm dmi 0 nm 0 lt_TRm
.model lt_TRm ltra r=0 g=0 l=2.25e-09 c=1.11111e-12 len=1
CESDm nm 0 2.5p
OCBm nm 0 fm 0 lt_CBm
.model lt_CBm ltra r=0 g=0 l=1.125e-07 c=5.55556e-11 len=1
CHSTm fm 0 2p
RHSTm fm 0 45
.tran 1e-11 1.02e-06 0 1e-11
.control
set wr_singlescale
set wr_vecnames
option numdgt=7
run
wrdata /home/Projects/USB_60/AFE/Discrete/Transmitter/sim/results/corner_static_BFT92_3.465_-40/wave.txt v(np) v(nm) v(fp) v(fm) v(dpi) v(dmi) i(vip) i(vin) i(vid) v(nem) v(et) v(bpi) v(bni) v(bdi) v(en)
quit
.endc
.end
