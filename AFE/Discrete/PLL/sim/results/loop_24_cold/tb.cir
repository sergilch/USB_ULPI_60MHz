* discrete PLL board - loop transient - generated by run_sims.py
.options reltol=1e-4 abstol=1e-12 method=gear maxord=2
VREF ref 0 PULSE(0 1 2e-09 1n 1n 1.98333e-08 4.16667e-08)
Aref [ref] [refd] adc1
.model adc1 adc_bridge(in_low=0.4 in_high=0.6)
Bvco 0 ph I=pwl(V(k), -1, 393.512, 0, 393.512, 0.25, 404.169, 0.5, 413.986, 1, 431.565, 1.5, 446.913, 2, 460.549, 2.5, 472.762, 3, 483.772, 3.5, 493.755, 4, 502.882, 4.5, 511.329, 4.75, 515.325, 6, 515.325) * V(en_v)
Cph ph 0 1u
Rph ph 0 1e12
Bdiv dv 0 V=0.5 + 0.5 * sin(6.283185307 * V(ph) / 20)
Adiv [dv] [divd] adc1
Ahi hi pu1
.model pu1 d_pullup
Alo lo pd1
.model pd1 d_pulldown
Aup hi refd lo rst up upb dff1
Adn hi divd lo rst dn dnb dff1
.model dff1 d_dff(clk_delay=0.3n set_delay=0.3n reset_delay=0.3n)
Aand [up dn] rst0 and1
.model and1 d_and(rise_delay=2.9e-09 fall_delay=0.3n)
Aenr [rst0 pdn] rst or1
.model or1 d_or(rise_delay=0.1n fall_delay=0.1n)
Aud [up dn] [upa dna] dac1
.model dac1 dac_bridge(out_low=0 out_high=1 t_rise=0.3n t_fall=0.3n)
Vpdn pdna 0 PWL(0 0 40u 0 40.01u 1 46u 1 46.01u 0)
Apdn [pdna] [pdn] adc1
Ben en_v 0 V=1
Bcp 0 vt I=0.00125 * (1.01 * V(upa) * 0.5 * (1 + tanh((4.5 - 0.25 - V(vt)) / 0.08)) - 0.99 * V(dna) * 0.5 * (1 + tanh((V(vt) - 0.25) / 0.08)))
C4 vt 0 2.7e-11
R2 vt z 2200
C3 z 0 1.5e-09
Rleak vt 0 1e10
Rk vt k 2200
Ck k 0 2.4e-11
Sdis vt 0 pdna 0 swd
.model swd sw vt=0.5 vh=0.05 ron=100 roff=1e11
.ic v(vt)=0 v(z)=0 v(k)=0 v(ph)=0
.tran 0.2n 8e-05 0 0.5n uic
.control
run
linearize v(vt) v(k)
wrdata /home/Projects/USB_60/AFE/Discrete/PLL/sim/results/loop_24_cold/wave.txt v(vt) v(k)
.endc
.end
