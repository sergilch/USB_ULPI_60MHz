* discrete PLL board - VCO (Q3 / Q4) - generated by run_sims.py
.include /home/Projects/USB_60/AFE/Discrete/PLL/sim/models/pll_models.lib
.options temp=27 tnom=27 reltol=1e-4 method=gear maxord=2
VCC vcc 0 4.82
VOFF off 0 PWL(0 5 50n 5 52n 0 1.05u 0 1.052u 5)
SQ5 x 0 off 0 swq5
.model swq5 sw vt=2.1 vh=0.1 ron=3 roff=1e9
CQ5 x 0 25p
VT vt 0 3.15
RC1 vcc c1 22
CC1 c1 0 100p
CC1b c1 0 10n
RB1b vcc x 4700
RB1a x b1 4700
RB2 b1 0 6800
XQ3 c1 b1 e1 BFR93A
RE1 e1 0 270
C1 b1 e1 1e-11
C2 e1 0 1e-11
Ccpl b1 t 3.3e-12
XL1 t lg LQW18_10N
Llg lg 0 0.3n
Cp t 0 1.5e-12
Cs t k 1.6e-11
XD1 0 k SV305
Rk vt k 2200
Cpar t 0 0.4p
Cb2 e1 b2 1.5e-12
RB3 vcc b2 10000
RB4 b2 0 4700
XQ4 c2 b2 e2 BFR93A
RE2 e2 0 100
CE2 e2 0 100p
RC2 vcc c2 220
Cout c2 inp 100p
Rbb inp vbb 2000
Cin inp 0 1.5p
VBB vbb 0 2.0
Rtap c2 sma 470
Rsma sma 0 50
.tran 20p 1.6e-06 0 20p
.control
run
wrdata /home/Projects/USB_60/AFE/Discrete/PLL/sim/results/vcostart/wave.txt v(inp) v(t) v(e1)
.endc
.end
