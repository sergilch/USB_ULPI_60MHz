// =============================================================================
// tb_usb3300_enum.vams
//
// Mixed-signal testbench: USB host enumeration of a low-speed HID mouse.
//
//   ulpi_link_bfm (digital)  --ULPI-->  USB3300 PHY (DUT)  --DP/DM-->  usb_ls_mouse (Verilog-A)
//
// The testbench plays the USB HOST: it configures the PHY through ULPI register
// access, detects the attach, resets the bus, and runs the standard enumeration
// sequence using the tasks of ulpi_tb_template.v:
//
//    attach detect -> debounce -> bus reset -> GET_DESCRIPTOR(dev,8) -> SET_ADDRESS
//    -> GET_DESCRIPTOR(dev,18) -> GET_DESCRIPTOR(cfg,9/34) -> SET_CONFIGURATION
//    -> SET_IDLE -> GET_DESCRIPTOR(HID report) -> poll EP1 for 3 mouse reports
//
// Build notes
//   * Needs a Verilog-AMS capable simulator (Xcelium AMS, Questa ADMS, VCS AMS).
//   * Do NOT compile ulpi_tb_template.v separately: it is `included below.
//   * The USB3300 simulation model is NOT supplied here.  Adapt the u_phy
//     instance (module / port names) to the model you have.  Its DP/DM ports must
//     be electrical (or the simulator must insert connect modules).
//   * Delays marked "scaled" are shortened versus the USB spec (e.g. 100 ms
//     debounce) to keep the mixed-signal run short; raise them for compliance runs.
// =============================================================================
`include "constants.vams"
`include "disciplines.vams"
`include "ulpi_tb_template.v"

`timescale 1ns/1ps

module tb_usb3300_enum;

  // ------------------------------------------------------------ parameters
  localparam [6:0] DEV_ADDR     = 7'd5;
  parameter integer RX_TO       = 60000;      // RX wait timeout [60 MHz clocks] (1 ms)
  parameter integer T_DEBOUNCE  = 100_000;    // ns, scaled (spec: 100 ms)
  parameter integer T_RECOVERY  = 50_000;     // ns, scaled (spec: 10 ms reset recovery)
  parameter integer T_SETADDR   = 20_000;     // ns, scaled (spec: 2 ms SET_ADDRESS recovery)
  parameter integer RESET_BYTES = 12;         // 0x00 bytes sent for bus reset (12 x 5.33 us ~ 64 us, scaled)
  parameter [7:0]   OTG_CTRL_VAL = 8'h66;     // DpPulldown | DmPulldown | DrvVbus | DrvVbusExternal

  localparam [7:0] FUNC_LS_HOST   = 8'h46;    // SuspendM=1, OpMode=00, TermSelect=1, XcvrSelect=10 (LS)
  localparam [7:0] FUNC_FS_HOST   = 8'h45;    // XcvrSelect=01 (FS), used to sense attach
  localparam [7:0] FUNC_LS_NONRZI = 8'h56;    // as LS but OpMode=10 (no bit-stuffing / NRZI)

  // ------------------------------------------------------------ nets
  electrical dp, dm;                 // USB D+ / D-
  wire       clk, dir, nxt, stp;     // ULPI (clk = PHY CLKOUT, 60 MHz)
  wire [7:0] data;
  reg        resetb;
  reg        xi;                     // 24 MHz crystal input of the USB3300

  initial begin xi = 1'b0; resetb = 1'b0; end
  always #20.8333 xi = ~xi;

  // ------------------------------------------------------------ DUT: USB3300 PHY
  // TODO: adapt to your USB3300 model (names below follow the datasheet pin names).
  usb3300 u_phy (
    .DATA   (data),
    .DIR    (dir),
    .NXT    (nxt),
    .STP    (stp),
    .CLKOUT (clk),
    .RESETB (resetb),
    .XI     (xi),
    .DP     (dp),
    .DM     (dm)
  );

  // ------------------------------------------------------------ device: HID mouse
  usb_ls_mouse #(.t_attach(30.0e-6)) u_mouse (.dp(dp), .dm(dm));

  // ------------------------------------------------------------ Link-side ULPI BFM
  // Low-speed bytes take ~5.3 us = 320 clocks, so nxt waits must be long.
  ulpi_link_bfm #(.NXT_TIMEOUT(4000)) u_link (
    .clk(clk), .dir(dir), .nxt(nxt), .data(data), .stp(stp)
  );

  // ============================================================ host-side state
  reg [7:0] ctl_buf [0:255];     // data received in control-read data stages
  integer   ctl_n;
  reg [7:0] rpt [0:3];           // last interrupt report
  integer   errors;
  reg [3:0] rx_pid;              // last received packet
  integer   rx_nbytes;           // bytes incl. PID and CRC
  reg       rx_ok;
  reg       int_tog;             // expected DATA toggle for EP1
  integer   max_pkt0;

  localparam [3:0] PID_OUT   = `ULPI_PID_OUT;
  localparam [3:0] PID_IN    = `ULPI_PID_IN;
  localparam [3:0] PID_SETUP = `ULPI_PID_SETUP;
  localparam [3:0] PID_DATA0 = `ULPI_PID_DATA0;
  localparam [3:0] PID_DATA1 = `ULPI_PID_DATA1;
  localparam [3:0] PID_ACK   = `ULPI_PID_ACK;
  localparam [3:0] PID_NAK   = `ULPI_PID_NAK;
  localparam [3:0] PID_STALL = `ULPI_PID_STALL;

  // ------------------------------------------------------------ check helper
  task check(input cond, input [8*48-1:0] msg);
    begin
      if (!cond) begin
        errors = errors + 1;
        $display("[%0t] TB ERROR: %0s", $time, msg);
      end else
        $display("[%0t] TB OK   : %0s", $time, msg);
    end
  endtask

  // ------------------------------------------------------------ CRC helpers
  // CRC16 over u_link.tx_buf[0..len-1]
  task crc16_tx(input integer len, output [15:0] crc);
    integer i, j; reg [15:0] c; reg [7:0] b;
    begin
      c = 16'hFFFF;
      for (i = 0; i < len; i = i + 1) begin
        b = u_link.tx_buf[i];
        for (j = 0; j < 8; j = j + 1)
          if (c[0] ^ b[j]) c = (c >> 1) ^ 16'hA001; else c = c >> 1;
      end
      crc = ~c;
    end
  endtask

  // CRC16 over u_link.rx_buf[first .. first+len-1]
  task crc16_rx(input integer first, input integer len, output [15:0] crc);
    integer i, j; reg [15:0] c; reg [7:0] b;
    begin
      c = 16'hFFFF;
      for (i = first; i < first + len; i = i + 1) begin
        b = u_link.rx_buf[i];
        for (j = 0; j < 8; j = j + 1)
          if (c[0] ^ b[j]) c = (c >> 1) ^ 16'hA001; else c = c >> 1;
      end
      crc = ~c;
    end
  endtask

  // ------------------------------------------------------------ packet-level host tasks
  task host_send_token(input [3:0] pid, input [6:0] addr, input [3:0] ep);
    reg [10:0] d; reg [4:0] c, cr; integer i;
    begin
      d = {ep, addr};
      c = 5'h1F;
      for (i = 0; i < 11; i = i + 1)
        if (c[4] ^ d[i]) c = {c[3:0], 1'b0} ^ 5'h05; else c = {c[3:0], 1'b0};
      c  = ~c;
      cr = {c[0], c[1], c[2], c[3], c[4]};          // transmitted MSB first
      u_link.tx_buf[0] = {ep[0], addr};
      u_link.tx_buf[1] = {cr, ep[3:1]};
      u_link.link_tx_packet(pid, 2);
    end
  endtask

  // DATA packet: payload already in u_link.tx_buf[0..len-1]; CRC16 appended here
  task host_send_data(input [3:0] pid, input integer len);
    reg [15:0] crc;
    begin
      crc16_tx(len, crc);
      u_link.tx_buf[len]     = crc[7:0];
      u_link.tx_buf[len + 1] = crc[15:8];
      u_link.link_tx_packet(pid, len + 2);
    end
  endtask

  task host_send_handshake(input [3:0] pid);
    begin u_link.link_tx_packet(pid, 0); end
  endtask

  // Wait for one packet from the device; fills rx_pid / rx_nbytes / rx_ok
  task host_wait_pkt(output ok);
    reg got; reg [7:0] b0;
    begin
      u_link.link_wait_rx_packet(RX_TO, got);
      rx_nbytes = u_link.rx_len;
      b0        = u_link.rx_buf[0];
      rx_pid    = b0[3:0];
      rx_ok     = got && (b0[7:4] == ~b0[3:0]) && !u_link.rx_err_seen;
      ok        = rx_ok;
    end
  endtask

  // ------------------------------------------------------------ control transfers
  // SETUP stage: token + DATA0(8 bytes) and ACK check
  task host_setup(input [6:0] addr, input [7:0] bm, input [7:0] br,
                  input [15:0] wv, input [15:0] wi, input [15:0] wl);
    reg ok;
    begin
      host_send_token(PID_SETUP, addr, 4'd0);
      u_link.tx_buf[0] = bm;        u_link.tx_buf[1] = br;
      u_link.tx_buf[2] = wv[7:0];   u_link.tx_buf[3] = wv[15:8];
      u_link.tx_buf[4] = wi[7:0];   u_link.tx_buf[5] = wi[15:8];
      u_link.tx_buf[6] = wl[7:0];   u_link.tx_buf[7] = wl[15:8];
      host_send_data(PID_DATA0, 8);
      host_wait_pkt(ok);
      check(ok && rx_pid == PID_ACK, "SETUP stage ACKed");
    end
  endtask

  // Control read: SETUP + IN data stage (8-byte packets) + OUT status stage
  task host_ctrl_read(input [6:0] addr, input [7:0] bm, input [7:0] br,
                      input [15:0] wv, input [15:0] wi, input [15:0] wl);
    reg ok, done, tog; reg [15:0] crc; integer tries, n, i;
    begin
      host_setup(addr, bm, br, wv, wi, wl);
      ctl_n = 0; tog = 1'b1; done = 1'b0; tries = 0;
      while (!done && tries < 100) begin
        host_send_token(PID_IN, addr, 4'd0);
        host_wait_pkt(ok);
        if (!ok) begin
          check(1'b0, "data-stage packet received");
          done = 1'b1;
        end else if (rx_pid == PID_NAK) begin
          tries = tries + 1;
        end else if (rx_pid == PID_DATA0 || rx_pid == PID_DATA1) begin
          n = rx_nbytes - 3;                               // minus PID and CRC16
          crc16_rx(1, n, crc);
          check({u_link.rx_buf[1 + n + 1], u_link.rx_buf[1 + n]} == crc, "data-stage CRC16");
          check((rx_pid == PID_DATA1) == tog,                "data-stage DATA toggle");
          for (i = 0; i < n; i = i + 1) ctl_buf[ctl_n + i] = u_link.rx_buf[1 + i];
          ctl_n = ctl_n + n;
          host_send_handshake(PID_ACK);
          tog = ~tog;
          if (n < 8 || ctl_n >= wl) done = 1'b1;
        end else begin
          check(1'b0, "unexpected PID in data stage (STALL?)");
          done = 1'b1;
        end
      end
      // status stage: zero-length DATA1 OUT
      host_send_token(PID_OUT, addr, 4'd0);
      host_send_data(PID_DATA1, 0);
      host_wait_pkt(ok);
      check(ok && rx_pid == PID_ACK, "status stage (OUT ZLP) ACKed");
    end
  endtask

  // Control transfer without data stage: SETUP + IN status (zero-length DATA1) + ACK
  task host_ctrl_nodata(input [6:0] addr, input [7:0] bm, input [7:0] br,
                        input [15:0] wv, input [15:0] wi);
    reg ok; integer tries, done;
    begin
      host_setup(addr, bm, br, wv, wi, 16'd0);
      done = 0; tries = 0;
      while (!done && tries < 100) begin
        host_send_token(PID_IN, addr, 4'd0);
        host_wait_pkt(ok);
        if (ok && rx_pid == PID_NAK) tries = tries + 1;
        else begin
          check(ok && rx_pid == PID_DATA1 && rx_nbytes == 3, "status stage (IN ZLP) received");
          if (ok) host_send_handshake(PID_ACK);
          done = 1;
        end
      end
    end
  endtask

  // Poll interrupt endpoint 1 until a report arrives
  task host_poll_report(input [6:0] addr, output got_rpt);
    reg ok; reg [15:0] crc; integer tries, i;
    begin
      got_rpt = 1'b0; tries = 0;
      while (!got_rpt && tries < 300) begin
        host_send_token(PID_IN, addr, 4'd1);
        host_wait_pkt(ok);
        if (ok && rx_pid == PID_NAK) begin
          tries = tries + 1;
          #(5_000);
        end else if (ok && (rx_pid == PID_DATA0 || rx_pid == PID_DATA1) && rx_nbytes == 7) begin
          crc16_rx(1, 4, crc);
          check({u_link.rx_buf[6], u_link.rx_buf[5]} == crc, "report CRC16");
          check((rx_pid == PID_DATA1) == int_tog,             "report DATA toggle");
          for (i = 0; i < 4; i = i + 1) rpt[i] = u_link.rx_buf[1 + i];
          host_send_handshake(PID_ACK);
          int_tog = ~int_tog;
          got_rpt = 1'b1;
        end else begin
          check(1'b0, "valid interrupt report or NAK");
          tries = 300;
        end
      end
    end
  endtask

  // ------------------------------------------------------------ port-level tasks
  // Wait for the device attach; returns 1 for low-speed (idle = K in FS terms), 2 for full-speed
  task host_wait_attach(output integer speed);
    reg [7:0] r; integer n;
    begin
      speed = 0; n = 0;
      while (speed == 0 && n < 2000) begin
        u_link.link_reg_read(`ULPI_REG_DEBUG, r);          // Debug register [1:0] = LineState
        if (r[1:0] == 2'b10)      speed = 1;               // D- high idle  -> low-speed device
        else if (r[1:0] == 2'b01) speed = 2;               // D+ high idle  -> full-speed device
        else #(2_000);
        n = n + 1;
      end
    end
  endtask

  // Drive SE0 (bus reset) for RESET_BYTES low-speed byte times.
  // NOTE: this follows the "OpMode=10, transmit NOPID + 0x00 data" convention; check the
  // exact way your USB3300 model/datasheet generates host SE0 and adapt here if needed.
  task host_bus_reset;
    integer i;
    begin
      u_link.link_reg_write(`ULPI_REG_FUNC_CTRL, FUNC_LS_NONRZI);
      for (i = 0; i < RESET_BYTES; i = i + 1) u_link.tx_buf[i] = 8'h00;
      u_link.link_tx_packet(4'h0, RESET_BYTES);            // TXCMD 0x40 (NOPID) + zero bytes
      u_link.link_reg_write(`ULPI_REG_FUNC_CTRL, FUNC_LS_HOST);
      #(T_RECOVERY);
    end
  endtask

  // ============================================================ main sequence
  integer speed, wtotal, i;
  reg [7:0] rd;
  reg got;

  initial begin
    errors = 0; int_tog = 1'b0; ctl_n = 0; max_pkt0 = 8;

    // ---- 1. power-up and PHY identification -----------------------------------
    #(1_000);  resetb = 1'b1;
    repeat (200) @(posedge clk);
    u_link.link_check_reg(`ULPI_REG_VENDOR_ID_LOW,  8'h24, 8'hFF);   // SMSC / Microchip 0x0424
    u_link.link_check_reg(`ULPI_REG_VENDOR_ID_HIGH, 8'h04, 8'hFF);
    u_link.link_check_reg(`ULPI_REG_PRODUCT_ID_LOW, 8'h04, 8'hFF);   // USB3300 = 0x0004
    u_link.link_check_reg(`ULPI_REG_PRODUCT_ID_HIGH,8'h00, 8'hFF);
    // scratch-register sanity check
    u_link.link_reg_write(`ULPI_REG_SCRATCH, 8'hA5);
    u_link.link_check_reg(`ULPI_REG_SCRATCH, 8'hA5, 8'hFF);

    // ---- 2. host configuration, wait for attach --------------------------------
    u_link.link_reg_write(`ULPI_REG_OTG_CTRL,  OTG_CTRL_VAL);        // pull-downs on, drive VBUS
    u_link.link_reg_write(`ULPI_REG_FUNC_CTRL, FUNC_FS_HOST);        // sense attach in FS mode
    host_wait_attach(speed);
    check(speed == 1, "low-speed device attached");
    #(T_DEBOUNCE);                                                   // attach debounce (scaled)
    u_link.link_reg_read(`ULPI_REG_DEBUG, rd);
    check(rd[1:0] == 2'b10, "attach stable after debounce");

    // ---- 3. bus reset in low-speed mode ------------------------------------------
    u_link.link_reg_write(`ULPI_REG_FUNC_CTRL, FUNC_LS_HOST);
    host_bus_reset;

    // ---- 4. first 8 bytes of device descriptor at address 0 ----------------------
    host_ctrl_read(7'd0, 8'h80, 8'h06, 16'h0100, 16'h0000, 16'd8);
    check(ctl_n == 8,               "device descriptor: 8 bytes");
    check(ctl_buf[1] == 8'h01,      "descriptor type = DEVICE");
    max_pkt0 = ctl_buf[7];
    check(max_pkt0 == 8,            "bMaxPacketSize0 = 8 (low-speed)");

    // ---- 5. SET_ADDRESS ------------------------------------------------------------
    host_ctrl_nodata(7'd0, 8'h00, 8'h05, {9'd0, DEV_ADDR}, 16'h0000);
    #(T_SETADDR);

    // ---- 6. full device descriptor at the new address -------------------------------
    host_ctrl_read(DEV_ADDR, 8'h80, 8'h06, 16'h0100, 16'h0000, 16'd18);
    check(ctl_n == 18,                              "device descriptor: 18 bytes");
    check({ctl_buf[9], ctl_buf[8]}   == 16'h1234,   "idVendor  = 0x1234");
    check({ctl_buf[11], ctl_buf[10]} == 16'h5678,   "idProduct = 0x5678");
    check(ctl_buf[17] == 8'h01,                     "bNumConfigurations = 1");

    // ---- 7. configuration descriptor (header, then full) ---------------------------
    host_ctrl_read(DEV_ADDR, 8'h80, 8'h06, 16'h0200, 16'h0000, 16'd9);
    wtotal = {ctl_buf[3], ctl_buf[2]};
    check(wtotal == 34, "wTotalLength = 34");
    host_ctrl_read(DEV_ADDR, 8'h80, 8'h06, 16'h0200, 16'h0000, wtotal);
    check(ctl_n == 34,                "configuration descriptor: 34 bytes");
    check(ctl_buf[14] == 8'h03,       "interface class = HID");
    check(ctl_buf[15] == 8'h01,       "interface subclass = boot");
    check(ctl_buf[16] == 8'h02,       "interface protocol = mouse");
    check(ctl_buf[29] == 8'h81,       "endpoint 1 IN");
    check(ctl_buf[30] == 8'h03,       "endpoint type = interrupt");

    // ---- 8. SET_CONFIGURATION(1) and HID class requests -----------------------------
    host_ctrl_nodata(DEV_ADDR, 8'h00, 8'h09, {8'd0, ctl_buf[5]}, 16'h0000);
    host_ctrl_nodata(DEV_ADDR, 8'h21, 8'h0A, 16'h0000, 16'h0000);        // SET_IDLE(0)
    host_ctrl_read  (DEV_ADDR, 8'h81, 8'h06, 16'h2200, 16'h0000, {ctl_buf[26], ctl_buf[25]}); // HID report descriptor
    check(ctl_n == 52,                "HID report descriptor: 52 bytes");
    check(ctl_buf[0] == 8'h05 && ctl_buf[1] == 8'h01 && ctl_buf[3] == 8'h02,
                                      "report descriptor: Generic Desktop / Mouse");

    // ---- 9. read three mouse reports from the interrupt endpoint -------------------
    host_poll_report(DEV_ADDR, got);
    check(got && rpt[0] == 8'h01 && rpt[1] == 8'h05 && rpt[2] == 8'hFD && rpt[3] == 8'h00,
          "report 1: left button, dX=+5, dY=-3");
    host_poll_report(DEV_ADDR, got);
    check(got && rpt[0] == 8'h00 && rpt[1] == 8'h10 && rpt[2] == 8'h00 && rpt[3] == 8'h01,
          "report 2: dX=+16, wheel=+1");
    host_poll_report(DEV_ADDR, got);
    check(got && rpt[0] == 8'h02 && rpt[1] == 8'hF0 && rpt[2] == 8'h08 && rpt[3] == 8'h00,
          "report 3: right button, dX=-16, dY=+8");

    // ---- 10. verdict -----------------------------------------------------------------
    errors = errors + u_link.err_cnt;
    if (errors == 0) $display("[%0t] ===== ENUMERATION TEST PASSED =====", $time);
    else             $display("[%0t] ===== ENUMERATION TEST FAILED: %0d error(s) =====", $time, errors);
    $finish;
  end

  // watchdog
  initial begin
    #(50_000_000);                                  // 50 ms of simulated time
    $display("[%0t] TB ERROR: watchdog timeout", $time);
    $finish;
  end

endmodule
